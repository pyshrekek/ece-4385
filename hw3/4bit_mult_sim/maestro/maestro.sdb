ADE simulation setup
Run mode: Single Run, Sweeps and Corners
Tests:
  hw3_4bit_mult_sim_1: hw3/4bit_mult_sim/schematic, simulator hspiceD
