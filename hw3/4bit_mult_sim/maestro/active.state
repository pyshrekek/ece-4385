ADE simulation setup
Test hw3_4bit_mult_sim_1: hw3/4bit_mult_sim/schematic, simulator hspiceD
  Models: /opt/PDK/FreePDK45/ncsu_basekit/models/hspice/hspice_nom.include
  Analysis tran: stop=100n step=10n
  Signals: /Y0, /Y1, /Y2, /Y3, /Y4, /Y5, /Y6, /Y7
Run mode: Single Run, Sweeps and Corners
