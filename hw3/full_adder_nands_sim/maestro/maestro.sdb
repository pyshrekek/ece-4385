ADE simulation setup
Run mode: Single Run, Sweeps and Corners
Tests:
  hw3_full_adder_nands_sim_1: hw3/full_adder_nands_sim/schematic, simulator hspiceD
