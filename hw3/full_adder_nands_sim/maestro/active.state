ADE simulation setup
Test hw3_full_adder_nands_sim_1: hw3/full_adder_nands_sim/schematic, simulator hspiceD
  Models: /opt/PDK/FreePDK45/ncsu_basekit/models/hspice/hspice_nom.include
  Analysis tran: stop=80n step=100p
  Signals: /carry_in, /in_A, /in_B, /carry_out, /sum
Run mode: Single Run, Sweeps and Corners
