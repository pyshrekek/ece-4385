ADE simulation setup
Run mode: Single Run, Sweeps and Corners
Tests:
  hw1_nor_simulation_1: hw1/nor_simulation/schematic, simulator hspiceD
