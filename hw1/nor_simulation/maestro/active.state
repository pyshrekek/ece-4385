ADE simulation setup
Test hw1_nor_simulation_1: hw1/nor_simulation/schematic, simulator hspiceD
  Models: /opt/PDK/FreePDK45/ncsu_basekit/models/hspice/hspice_nom.include
  Analysis tran: start=0 stop=6n step=20p
  Signals: /in_A, /in_B, /out
Run mode: Single Run, Sweeps and Corners
