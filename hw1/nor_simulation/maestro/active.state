ADE simulation setup
Test hw1_nor_simulation_1: hw1/nor_simulation/schematic, simulator hspiceD
  Models: /opt/PDK/FreePDK45/ncsu_basekit/models/hspice/hspice_nom.include, /opt/PDK/FreePDK45/ncsu_basekit/models/hspice/tran_models/models_nom/PMOS_VTL.inc, /opt/PDK/FreePDK45/ncsu_basekit/models/hspice/tran_models/models_nom/PMOS_VTH.inc, /opt/PDK/FreePDK45/ncsu_basekit/models/hspice/tran_models/models_nom/PMOS_VTG.inc, /opt/PDK/FreePDK45/ncsu_basekit/models/hspice/tran_models/models_nom/PMOS_THKOX.inc, /opt/PDK/FreePDK45/ncsu_basekit/models/hspice/tran_models/models_nom/NMOS_VTL.inc, /opt/PDK/FreePDK45/ncsu_basekit/models/hspice/tran_models/models_nom/NMOS_VTH.inc, /opt/PDK/FreePDK45/ncsu_basekit/models/hspice/tran_models/models_nom/NMOS_VTG.inc, /opt/PDK/FreePDK45/ncsu_basekit/models/hspice/tran_models/models_nom/NMOS_THKOX.inc
  Analysis tran: start=0 stop=6n step=20p
  Signals: /in_A, /in_B, /out
Run mode: Single Run, Sweeps and Corners
