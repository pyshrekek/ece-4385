ADE simulation setup
Test hw1_inv_simulation_1: hw1/inv_simulation/schematic, simulator hspiceD
  Models: /opt/PDK/FreePDK45/ncsu_basekit/models/hspice/hspice_nom.include
  Analysis dc: sweep source start=0 stop=1
  Signals: /in, /out
Run mode: Single Run, Sweeps and Corners
