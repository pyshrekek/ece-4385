ADE simulation setup
Run mode: Single Run, Sweeps and Corners
Tests:
  hw1_inv_simulation_1: hw1/inv_simulation/schematic, simulator hspiceD
