ADE simulation setup
Test hw1_nand_simulation_1: hw1/nand_simulation/schematic, simulator hspiceD
  Models: /opt/PDK/FreePDK45/ncsu_basekit/models/hspice/hspice_nom.include
  Analysis tran: stop=40n step=10p
  Signals: /in_A, /in_B, /out
Run mode: Single Run, Sweeps and Corners
