ADE simulation setup
Run mode: Single Run, Sweeps and Corners
Tests:
  hw1_nand_simulation_1: hw1/nand_simulation/schematic, simulator hspiceD
