ADE simulation setup
Run mode: Single Run, Sweeps and Corners
Tests:
  hw2_half_adder_sim_1: hw2/half_adder_sim/schematic, simulator hspiceD
