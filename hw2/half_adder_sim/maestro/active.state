ADE simulation setup
Test hw2_half_adder_sim_1: hw2/half_adder_sim/schematic, simulator hspiceD
  Models: /opt/PDK/FreePDK45/ncsu_basekit/models/hspice/hspice_nom.include
  Analysis tran: stop=40n step=10p
  Signals: /carry_out, /sum, /in_A, /in_B
Run mode: Single Run, Sweeps and Corners
