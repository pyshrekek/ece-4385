ADE simulation setup
Test hw2_4bit_adder_critpath_1: hw2/4bit_adder_critpath/schematic, simulator hspiceD
  Models: /opt/PDK/FreePDK45/ncsu_basekit/models/hspice/hspice_nom.include
  Analysis tran: stop=20n step=10p
  Signals: /Cin, /Cout, /S0, /S1, /S2, /S3
Run mode: Single Run, Sweeps and Corners
