ADE simulation setup
Run mode: Single Run, Sweeps and Corners
Tests:
  hw2_4bit_adder_sim_1: hw2/4bit_adder_sim/schematic, simulator hspiceD
