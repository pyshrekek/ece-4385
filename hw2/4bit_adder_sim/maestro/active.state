ADE simulation setup
Test hw2_4bit_adder_sim_1: hw2/4bit_adder_sim/schematic, simulator hspiceD
  Models: /opt/PDK/FreePDK45/ncsu_basekit/models/hspice/hspice_nom.include
  Analysis tran: stop=2.56u step=100p
  Signals: /Cin, /B3, /B2, /B1, /B0, /A3, /A2, /A1, /A0, /Cout, /S0, /S1, /S2, /S3
Run mode: Single Run, Sweeps and Corners
