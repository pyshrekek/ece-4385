ADE simulation setup
Test hw2_full_adder_sim_1: hw2/full_adder_sim/schematic, simulator hspiceD
  Models: /opt/PDK/FreePDK45/ncsu_basekit/models/hspice/hspice_nom.include
  Analysis tran: stop=80n step=10p
  Signals: /in_A, /carry_in, /in_B, /carry_out, /sum
Run mode: Single Run, Sweeps and Corners
