ADE simulation setup
Run mode: Single Run, Sweeps and Corners
Tests:
  hw2_full_adder_sim_1: hw2/full_adder_sim/schematic, simulator hspiceD
