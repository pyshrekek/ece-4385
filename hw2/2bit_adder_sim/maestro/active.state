ADE simulation setup
Test hw2_2bit_adder_sim_1: hw2/2bit_adder_sim/schematic, simulator hspiceD
  Models: /opt/PDK/FreePDK45/ncsu_basekit/models/hspice/hspice_nom.include
  Analysis tran: stop=320n step=100p
  Signals: /A0, /A1, /B0, /B1, /Cin, /Cout, /S0, /S1
Run mode: Single Run, Sweeps and Corners
