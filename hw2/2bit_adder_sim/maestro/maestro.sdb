ADE simulation setup
Run mode: Single Run, Sweeps and Corners
Tests:
  hw2_2bit_adder_sim_1: hw2/2bit_adder_sim/schematic, simulator hspiceD
